* e4_drift_R100k
.include ../models.lib
VCC vcc 0 12
VEE vee 0 -12
Vg g 0 dc 0 sin(0 1.0 100.0 0 0 90)
Rs g ui 50
R1 p 0 10k
R2 ui n 10k
C1 n uo 100n ic=0
XU p n vcc vee uo LM358 params: vos=2m
R3 n uo 100k

.options reltol=1e-4 abstol=1e-12 vntol=1e-7

.control
set wr_singlescale
set wr_vecnames
option numdgt=9
tran 50u 8 0 50u uic

wrdata out.txt v(uo)
quit
.endc
.end
