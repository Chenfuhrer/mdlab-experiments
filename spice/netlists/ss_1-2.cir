* ss_1-2
.include ../models.lib

VCC vcc 0 12
Vs us 0 dc 0 sin(0 0.5 10000.0)
R1 us ui 5.1k
R2 ui 0 51
C1 ui a 10u
R3 vcc a 100k
R5 a 0 24k
R4 vcc c 9k
Q1 c a e Q2N5551
R6 e e2 100
R7 e2 0 1.8k
C3 e 0 10u
C2 c o 10u
Rscope o 0 1Meg

.options reltol=1e-4 abstol=1e-12 vntol=1e-7

.control
set filetype=ascii
op
print @q1[gm]
print @q1[gpi]
print @q1[go]
print @q1[ic]
print @q1[ib]
quit
.endc
.end
