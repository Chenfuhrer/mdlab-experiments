* P_gen_50
.include ../models.lib

Vg g 0 dc 0 sin(0 1.0 1k)
Rs g o 50
Rscope o 0 1Meg
Cscope o 0 16p

.options reltol=1e-4 abstol=1e-12 vntol=1e-7

.control
set wr_singlescale
set wr_vecnames
option numdgt=9
tran 1u 10m 5m 1u

wrdata out.txt v(o)
quit
.endc
.end
