* val_beta
.include ../models.lib

VCC vcc 0 12
R3 vcc b 100k
R5 b 0 24k
R4 vcc c 5.1k
Q1 c b e Q2N5551
R6 e e2 100
R7 e2 0 1.8k

.options reltol=1e-4 abstol=1e-12 vntol=1e-7

.control
set filetype=ascii
op
print @q1[ic]
print @q1[ib]
print v(b)
print v(c)
print v(e)
quit
.endc
.end
