* e5_hp_tran_130
.include ../models.lib
VCC vcc 0 12
VEE vee 0 -12
Vi ui 0 dc 0 sin(0 0.5 130)
C1 ui x 100n
C2 x p 100n
R1 x uo 10k
R2 p 0 10k
R3 n 0 10k
Rf n uo 5858
XU p n vcc vee uo LM358

.options reltol=1e-4 abstol=1e-12 vntol=1e-7

.control
set wr_singlescale
set wr_vecnames
option numdgt=9
tran 1.5384615384615384e-05 0.3076923076923077 0.24615384615384617 1.5384615384615384e-05

wrdata out.txt v(ui) v(uo)
quit
.endc
.end
