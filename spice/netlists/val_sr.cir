* val_sr
.include ../models.lib

VCC vcc 0 12
VEE vee 0 -12
Vin in 0 pulse(-5 5 10u 1n 1n 100u 200u)
XU in out vcc vee out LM358
RL out 0 10k

.options reltol=1e-4 abstol=1e-12 vntol=1e-7

.control
set wr_singlescale
set wr_vecnames
option numdgt=9
tran 10n 80u

wrdata out.txt v(out)
quit
.endc
.end
