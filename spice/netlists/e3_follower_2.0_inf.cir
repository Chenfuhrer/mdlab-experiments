* e3_follower_2.0_inf
.include ../models.lib
VCC vcc 0 12
VEE vee 0 -12
Vi ui 0 dc 0 sin(0 1.0 1000.0 0 0 0)
XU ui uo vcc vee uo LM358

.options reltol=1e-4 abstol=1e-12 vntol=1e-7

.control
set wr_singlescale
set wr_vecnames
option numdgt=9
tran 2e-06 0.008 0.004 2e-06

wrdata out.txt v(ui) v(uo)
quit
.endc
.end
