* val_VOL
.include ../models.lib

VCC vcc 0 12
VEE vee 0 -12
Vin inp 0 dc -1
XU inp 0 vcc vee out LM358
RL out 0 5.1k

.options reltol=1e-4 abstol=1e-12 vntol=1e-7

.control
set filetype=ascii
op
print v(out)
quit
.endc
.end
