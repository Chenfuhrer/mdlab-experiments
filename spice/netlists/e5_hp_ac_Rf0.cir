* e5_hp_ac_Rf0
.include ../models.lib
VCC vcc 0 12
VEE vee 0 -12
Vi ui 0 dc 0 ac 1
C1 ui x 100n
C2 x p 100n
R1 x uo 10k
R2 p 0 10k
R3 n 0 10k
Rf n uo 0.001
XU p n vcc vee uo LM358

.options reltol=1e-4 abstol=1e-12 vntol=1e-7

.control
set wr_singlescale
set wr_vecnames
option numdgt=9
ac dec 200 1 1meg

wrdata out.txt v(uo)
quit
.endc
.end
