* e4_diff_square
.include ../models.lib
VCC vcc 0 12
VEE vee 0 -12
Vg g 0 dc 0 pulse(0.05 -0.05 0.0025 10n 10n 0.00499999 0.01)
Rs g ui 50
R1 p 0 10k
C1 ui n 220n
Rf n uo 10k
XU p n vcc vee uo LM358

.options reltol=1e-4 abstol=1e-12 vntol=1e-7

.control
set wr_singlescale
set wr_vecnames
option numdgt=9
tran 2e-07 0.05 0.01 2e-07

wrdata out.txt v(ui) v(uo)
quit
.endc
.end
