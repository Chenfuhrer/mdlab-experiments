* e2_Ri_ac
.include ../models.lib

VCC vcc 0 12
Vs us 0 dc 0 ac 1
R1 us ui 5.1k

C1 ui a 10u
R3 vcc a 100k
R5 a 0 24k
R4 vcc c 5.1k
Q1 c a e Q2N5551
R6 e e2 100
R7 e2 0 1.8k
C3 e 0 10u
C2 c o 10u
Rscope o 0 1Meg

.options reltol=1e-4 abstol=1e-12 vntol=1e-7

.control
set wr_singlescale
set wr_vecnames
option numdgt=9
ac lin 1 10000.0 10000.0

wrdata out.txt v(a) i(vs)
quit
.endc
.end
