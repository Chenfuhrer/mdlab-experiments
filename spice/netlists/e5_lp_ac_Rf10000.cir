* e5_lp_ac_Rf10000
.include ../models.lib
VCC vcc 0 12
VEE vee 0 -12
Vi ui 0 dc 0 ac 1
R3 ui x 10k
R2 x p 10k
C1 x uo 10n
C2 p 0 10n
R1 n 0 10k
Rf n uo 10000.0
XU p n vcc vee uo LM358

.options reltol=1e-4 abstol=1e-12 vntol=1e-7

.control
set wr_singlescale
set wr_vecnames
option numdgt=9
ac dec 200 1 1meg

wrdata out.txt v(uo)
quit
.endc
.end
