* e1_tran_1-3_1.0
.include ../models.lib

VCC vcc 0 12
Vs us 0 dc 0 sin(0 0.5 10000.0)
R1 us ui 5.1k
R2 ui 0 51
C1 ui a 10u
R3 vcc a 100k
R5 a 0 15k
R4 vcc c 5.1k
Q1 c a e Q2N5551
R6 e e2 100
R7 e2 0 1.8k
C3 e 0 10u
C2 c o 10u
Rscope o 0 1Meg

.options reltol=1e-4 abstol=1e-12 vntol=1e-7

.control
set wr_singlescale
set wr_vecnames
option numdgt=9
tran 2.5e-07 0.10060000000000001 0.1 2.5e-07

wrdata out.txt v(ui) v(o) v(us) v(c)
quit
.endc
.end
