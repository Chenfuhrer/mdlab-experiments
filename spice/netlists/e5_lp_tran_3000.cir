* e5_lp_tran_3000
.include ../models.lib
VCC vcc 0 12
VEE vee 0 -12
Vi ui 0 dc 0 sin(0 0.5 3000.0)
R3 ui x 10k
R2 x p 10k
C1 x uo 10n
C2 p 0 10n
R1 n 0 10k
Rf n uo 5858
XU p n vcc vee uo LM358

.options reltol=1e-4 abstol=1e-12 vntol=1e-7

.control
set wr_singlescale
set wr_vecnames
option numdgt=9
tran 6.666666666666666e-07 0.013333333333333332 0.010666666666666666 6.666666666666666e-07

wrdata out.txt v(ui) v(uo)
quit
.endc
.end
